// Copyright lowRISC contributors.
// Licensed under the Apache License, Version 2.0, see LICENSE for details.
// SPDX-License-Identifier: Apache-2.0

{ name: "pattgen",
  clock_primary: "clk_i",
  bus_device: "tlul",
  bus_host: "none",
  estimated_gate: "1k",
  regwidth: "32",
  // OUTPUT pins
  available_output_list: [
    { name: "pda0_tx", desc: "Serial output data bit for pattern generation on channel 0" }
    { name: "pcl0_tx", desc: "Bit-banging output clock for pattern generation on channel 0" }
    { name: "pda1_tx", desc: "Serial output data bit for pattern generation on channel 1" }
    { name: "pcl1_tx", desc: "Bit-banging output clock for pattern generation on channel 1" }
  ]
  // INTERRUPT pins
  interrupt_list: [
    { name: "patt_done0"
      desc: "raise if pattern generation on channel 0 is complete"
    }
    { name: "patt_done1"
      desc: "raise if pattern generation on channel 1 is complete"
    }
  ],
  param_list: [
    { name:    "NumRegsData",
      type:    "int",
      default: "2",
      desc:    "Number of data registers per each channel",
      local:   "true"
    }
  ],
  // REGISTER definition
  registers: [
    // CTRL register
    { name: "PATT_CTRL",
      desc: "PATTGEN control register",
      swaccess: "rw",
      hwaccess: "hro",
      fields: [
        { bits: "0",
          resval: "0",
          name: "ENABLE_CH0",
          desc: "Enable pattern generator functionality for channel 0"
        }
        { bits: "1",
          resval: "0",
          name: "ENABLE_CH1",
          desc: "Enable pattern generator functionality for channel 1"
        }
        { bits: "2",
          resval: "0",
          name: "POLARITY_CH0",
          desc: "Clock (`pcl`) polarity for channel 0.  If high, `pda` signal changes on falling edge of pcl signal, otherwise pda changes on rising edge"
        }
        { bits: "3",
          resval: "0",
          name: "POLARITY_CH1",
	  desc: "Clock (`pcl`) polarity for channel 1.  If high, `pda` signal changes on falling edge of `pcl` signal, otherwise pda changes on rising edge"

          desc: "Enable pattern generator functionality for channel 0"
        }
      ]
    }
    { name: "PATT_PREDIV_CH0",
      desc: "PATTGEN pre-divider multi-registers for channel 0",
      count: "NumRegsPrediv",
      cname: "PATTGEN",
      swaccess: "wo",
      hwaccess: "hro",
      hwqe: "true",
      fields: [
        { bits: "31:0",
          resval: "0",
          name: "CLK_RATIO",
          desc: "Divider ratio from based I/O clock for channel 0"
        }
      ]
    },
    { name: "PATT_PREDIV_CH1",
      desc: "PATTGEN pre-divider multi-registers for channel 1",
      count: "NumRegsPrediv",
      cname: "PATTGEN",
      swaccess: "wo",
      hwaccess: "hro",
      hwqe: "true",
      fields: [
        { bits: "31:0",
          resval: "0",
          name: "CLK_RATIO",
          desc: "Divider ratio from based I/O clock for channel 1"
        }
      ]
    },
    { multireg: {
        name: "PATT_DATA_CH0",
        desc: "PATTGEN Seed pattern multi-registers for channel 0",
        count: "NumRegsData",
        cname: "PATTGEN",
        swaccess: "wo",
        hwaccess: "hro",
        hwqe: "true",
        fields: [
          { bits: "31:0",
            resval: "0",
            name: "DATA",
            desc: "Seed pattern for channel 0 (2-64 bits)"
          }
        ]
      }
    },
    { multireg: {
        name: "PATT_DATA_CH1",
        desc: "PATTGEN Seed pattern multi-registers for channel 1",
        count: "NumRegsData",
        cname: "PATTGEN",
        swaccess: "wo",
        hwaccess: "hro",
        hwqe: "true",
        fields: [
          { bits: "31:0",
            resval: "0",
            name: "DATA",
            desc: "Seed pattern for channel 1 (2-64 bits)"
          }
        ]
      }
    },
    { name: "PATT_SIZE",
      desc: "PATTGEN pattern length",
      swaccess: "wo",
      hwaccess: "hro",
      hwqe: "true",
      fields: [
        { bits: "5:0",
          resval: "0",
          name: "LEN_CH0",
          desc: "Length of the seed pattern for channel 0 (1-64 bits), minus 1"
        }
        { bits: "15:6",
          resval: "0",
          name: "REPS_CH0",
          desc: "Number of pattern repetitions for channel 0, minus 1"
        }	  	
        { bits: "21:16",
          resval: "0",
          name: "LEN_CH1",
          desc: "Length of the seed pattern for channel 1 (1-64 bits), minus 1"
        }
        { bits: "31:22",
          resval: "0",
          name: "REPS_CH1",
          desc: "Number of pattern repetitions for channel 1, minus 1"
        }	  	
      ]
    }
  ]
}
